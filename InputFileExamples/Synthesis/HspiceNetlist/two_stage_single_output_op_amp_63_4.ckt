** Name: two_stage_single_output_op_amp_63_4

.MACRO two_stage_single_output_op_amp_63_4 ibias in1 in2 out sourceNmos sourcePmos
mMainBias1 outVoltageBiasXXnXX1 outVoltageBiasXXnXX1 sourceNmos sourceNmos nmos4 L=2e-6 W=5e-6
mMainBias2 outVoltageBiasXXnXX2 outVoltageBiasXXnXX2 sourceNmos sourceNmos nmos4 L=2e-6 W=17e-6
mFoldedCascodeFirstStageLoad3 FirstStageYinnerTransistorStack1Load2 FirstStageYinnerTransistorStack1Load2 sourcePmos sourcePmos pmos4 L=1e-6 W=26e-6
mFoldedCascodeFirstStageLoad4 FirstStageYout1 FirstStageYout1 FirstStageYinnerTransistorStack1Load2 FirstStageYinnerTransistorStack1Load2 pmos4 L=1e-6 W=106e-6
mMainBias5 ibias ibias outSourceVoltageBiasXXpXX1 outSourceVoltageBiasXXpXX1 pmos4 L=1e-6 W=24e-6
mMainBias6 outSourceVoltageBiasXXpXX1 outSourceVoltageBiasXXpXX1 sourcePmos sourcePmos pmos4 L=1e-6 W=10e-6
mFoldedCascodeFirstStageLoad7 FirstStageYout1 outVoltageBiasXXnXX1 FirstStageYsourceGCC1 FirstStageYsourceGCC1 nmos4 L=2e-6 W=227e-6
mFoldedCascodeFirstStageLoad8 FirstStageYsourceGCC1 outVoltageBiasXXnXX2 sourceNmos sourceNmos nmos4 L=2e-6 W=344e-6
mFoldedCascodeFirstStageLoad9 FirstStageYsourceGCC2 outVoltageBiasXXnXX2 sourceNmos sourceNmos nmos4 L=2e-6 W=344e-6
mSecondStage1Transconductor10 SecondStageYinnerTransconductance outFirstStage sourceNmos sourceNmos nmos4 L=1e-6 W=264e-6
mSecondStage1Transconductor11 out outVoltageBiasXXnXX1 SecondStageYinnerTransconductance SecondStageYinnerTransconductance nmos4 L=2e-6 W=531e-6
mFoldedCascodeFirstStageLoad12 outFirstStage outVoltageBiasXXnXX1 FirstStageYsourceGCC2 FirstStageYsourceGCC2 nmos4 L=2e-6 W=227e-6
mFoldedCascodeFirstStageStageBias13 FirstStageYinnerStageBias outSourceVoltageBiasXXpXX1 sourcePmos sourcePmos pmos4 L=1e-6 W=227e-6
mFoldedCascodeFirstStageLoad14 FirstStageYinnerTransistorStack2Load2 FirstStageYinnerTransistorStack1Load2 sourcePmos sourcePmos pmos4 L=1e-6 W=26e-6
mFoldedCascodeFirstStageTransconductor15 FirstStageYsourceGCC1 in1 FirstStageYsourceTransconductance FirstStageYsourceTransconductance pmos4 L=9e-6 W=505e-6
mFoldedCascodeFirstStageTransconductor16 FirstStageYsourceGCC2 in2 FirstStageYsourceTransconductance FirstStageYsourceTransconductance pmos4 L=9e-6 W=505e-6
mFoldedCascodeFirstStageStageBias17 FirstStageYsourceTransconductance ibias FirstStageYinnerStageBias FirstStageYinnerStageBias pmos4 L=1e-6 W=564e-6
mSecondStage1StageBias18 SecondStageYinnerStageBias outSourceVoltageBiasXXpXX1 sourcePmos sourcePmos pmos4 L=1e-6 W=499e-6
mSecondStage1StageBias19 out ibias SecondStageYinnerStageBias SecondStageYinnerStageBias pmos4 L=1e-6 W=599e-6
mFoldedCascodeFirstStageLoad20 outFirstStage FirstStageYout1 FirstStageYinnerTransistorStack2Load2 FirstStageYinnerTransistorStack2Load2 pmos4 L=1e-6 W=106e-6
mMainBias21 outVoltageBiasXXnXX1 outSourceVoltageBiasXXpXX1 sourcePmos sourcePmos pmos4 L=1e-6 W=52e-6
mMainBias22 outVoltageBiasXXnXX2 outSourceVoltageBiasXXpXX1 sourcePmos sourcePmos pmos4 L=1e-6 W=16e-6
mLoadCapacitor1 out sourceNmos 20e-12
mCompensationCapacitor2 outFirstStage out 16.4001e-12
.EOM two_stage_single_output_op_amp_63_4

** Expected Performance Values:
** Gain: 180 dB
** Power consumption: 6.27001 mW
** Area: 14999 (mu_m)^2
** Transit frequency: 6.49701 MHz
** Transit frequency with error factor: 6.49681 MHz
** Slew rate: 13.085 V/mu_s
** Phase margin: 61.8795°
** CMRR: 132 dB
** VoutMax: 3.98001 V
** VoutMin: 0.300001 V
** VcmMax: 3.15001 V
** VcmMin: -0.409999 V

** Expected Currents:
** NormalTransistorPmos: -5.27209e+07 muA
** NormalTransistorPmos: -1.61909e+07 muA
** NormalTransistorNmos: 2.16176e+08 muA
** NormalTransistorNmos: 3.29573e+08 muA
** NormalTransistorNmos: 2.16176e+08 muA
** NormalTransistorNmos: 3.29573e+08 muA
** DiodeTransistorPmos: -2.16175e+08 muA
** DiodeTransistorPmos: -2.16176e+08 muA
** NormalTransistorPmos: -2.16175e+08 muA
** NormalTransistorPmos: -2.16176e+08 muA
** NormalTransistorPmos: -2.26796e+08 muA
** NormalTransistorPmos: -2.26797e+08 muA
** NormalTransistorPmos: -1.13397e+08 muA
** NormalTransistorPmos: -1.13397e+08 muA
** NormalTransistorNmos: 5.05928e+08 muA
** NormalTransistorNmos: 5.05927e+08 muA
** NormalTransistorPmos: -5.05925e+08 muA
** NormalTransistorPmos: -5.05924e+08 muA
** DiodeTransistorNmos: 5.27201e+07 muA
** DiodeTransistorNmos: 1.61901e+07 muA
** DiodeTransistorPmos: -9.99899e+06 muA
** DiodeTransistorPmos: -1e+07 muA

** Expected Voltages:
** ibias: 3.48201  V
** in1: 2.5  V
** in2: 2.5  V
** out: 2.5  V
** outFirstStage: 0.555001  V
** outSourceVoltageBiasXXpXX1: 4.19901  V
** outVoltageBiasXXnXX1: 0.905001  V
** outVoltageBiasXXnXX2: 0.555001  V
** sourceNmos: 0  V
** sourcePmos: 5  V
** innerStageBias: 4.19601  V
** innerTransistorStack1Load2: 3.75101  V
** innerTransistorStack2Load2: 3.74901  V
** out1: 2.84801  V
** sourceGCC1: 0.350001  V
** sourceGCC2: 0.350001  V
** sourceTransconductance: 3.39901  V
** innerStageBias: 4.26301  V
** innerTransconductance: 0.350001  V

.END
